* ========================
* cmos inverter simulation
* ========================

* ==============
* power supplies
* ==============

vdd vdd 0 dc 1.0

* vdd -> name of source
* vdd -> positive node
* 0   -> ground node
* dc  -> dc value type
* 1.0 -> voltage in volts

* =====================
* 2. input pulse source
* =====================

vin in 0 pulse(0 1.0 0.5n 0.1n 0.1n 50n 100n)

* vin -> name of source
* in  -> positive node connected to inverter input
* 0   -> ground node
* pulse(v1 v2 td tr tf pw per): pulse waveform
*   v1  = 0    -> initial voltage in volts
*   v2  = 1.0  -> pulsed voltage in volts
*   td  = 10m  -> delay time before first pulse starts, in seconds
*   tr  = 0.1n -> rise time 0->1, in seconds
*   tf  = 0.1n -> fall time 1->0, in seconds
*   pw  = 50n  -> pulse width, time signal stays at v2, in seconds
*   per = 100n -> period of the pulse, in seconds. 100ns = 10mhz

* ==============
* 3. transistors
* ==============

m1 out in vdd vdd pmos l=100n w=150n

* m1     -> pmos transistor name
* out    -> drain node              = inverter output
* in     -> gate node               = inverter input
* vdd    -> source node             = tied to vdd
* vdd    -> bulk/body node          = tied to vdd for pmos
* pmos   -> model name
* l=100n -> channel length
* w=150n -> channel width

m2 out in 0 0 nmos l=100n w=200n

* m2     -> nmos transistor name
* out    -> drain node             = inverter output
* in     -> gate node              = inverter input
* 0      -> source node            = tied to gnd
* 0      -> bulk/body node         = tied to gnd for nmos
* nmos   -> model name
* l=100n -> channel length
* w=200n -> channel width

* ===================
* 4. load capacitance
* ===================

cload out 0 10f

* cload: name of capacitor
* out -> positive node connected to output
* 0   -> negative node connected to ground
* 10f -> capacitance value = 10 ff = 10e-15 farads

* =======================================
* 5. mosfet models - level 1 simple model
* =======================================

.model nmos nmos level=1 vto=0.5 kp=120u lambda=0.06

* .model      -> defines a model
* nmos        -> model name to reference above
* nmos        -> model type
* level=1     -> shichman-hodges model. simplest, good for hand calc
* vto=0.5     -> threshold voltage vth in volts
* kp=120u     -> transconductance parameter u_n*cox in a/v^2
* lambda=0.06 -> channel length modulation in 1/v

.model pmos pmos level=1 vto=-0.5 kp=40u lambda=0.06

* vto=-0.5    -> negative threshold for pmos
* kp=40u      -> lower mobility for holes
* lambda=0.06 -> same channel length modulation

* ======================
* 6. simulation commands
* ======================

.tran 0.05n 200n

* .tran -> transient analysis
* 0.05n -> timestep = 0.05 ns. must be << rise time for accuracy
* 200n  -> stop time = 200 ns. simulates 2 full periods

* =======================
* 7. measurement commands
* =======================

* format -> .measure tran <result_name> <type> <args>
* 'tran' means measure after transient sim

* delay measurements -> 50% vdd crossing = 0.9v for 1.8v supply

***** .measure tran tphl trig v(in) val=0.5 rise=1 targ v(out) val=0.5 fall=1

* tphl -> name of result = tphl high to low delay
* trig -> trigger condition to start timer
*   v(in)   -> monitor input voltage
*   val=0.9 -> when it crosses 0.9v
*   rise=1  -> on the 1st rising edge
* targ -> target condition to stop timer
*   v(out)  -> monitor output voltage
*   val=0.9 -> when it crosses 0.9v
*   fall=1  -> on the 1st falling edge

***** .measure tran tplh trig v(in) val=0.5 fall=1 targ v(out) val=0.5 rise=1

* tplh -> tplh low to high delay. opposite edges of tphl

***** .measure tran tpd param='(tphl+tplh)/2'

* tpd   -> average propagation delay
* param -> calculate from previous measurements

* slew rate measurements: 20% to 80% points

***** .measure tran trise trig v(out) val=0.2 rise=1 targ v(out) val=0.8 rise=1

* trise -> output rise time
* 0.2 = 20% of 1.0v, 0.8 = 80% of 1.0v

***** .measure tran tfall trig v(out) val=0.8 fall=1 targ v(out) val=0.2 fall=1

* tfall -> output fall time

* power measurement

***** .measure tran pavg avg p(vdd) from=50n to=150n

* pavg             -> average power
* avg              -> take average
* p(vdd)           -> instantaneous power from vdd source = v * i
* from=50n to=150n -> only average over 1 full period to avoid startup

* ==========================
* 8. save nodes for plotting
* ==========================

***** .save v(in) v(out) i(vdd)

* .save  -> save these for plot after sim
* v(in)  ->  input voltage waveform
* v(out) -> output voltage waveform
* i(vdd) -> current from supply, used for power

.control

run

* set output format to plain numbers (optional, disables headers)
set ascii_rawfile

set wr_singlescale

* write time, v(in), and v(out) into output.txt
wrdata output.txt v(in) v(out) i(vdd)
.endc

* .end -> end of netlist
