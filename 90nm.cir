.include models/90nm.pm

.param volt = 1.0V
.param pw = 360nm
.param nw = 180nm
.param pl = 90nm
.param nl = 90nm
.param cload = 1fF

vdd vdd 0 dc {volt}

vreg in 0 pulse(0 {volt} 5ps 10ps 10ps 0.5ns 1ns)
vres rin 0 pulse(0 {volt} 5ps 10ps 10ps 0.5ns 1ns)

res rin rout 100kΩ

mprc rcout rout vdd vdd pmos l={pl} w={pw}
mnrc rcout rout 0 0 nmos l={nl} w={nw}

mp out in vdd vdd pmos l={pl} w={pw}
mn out in 0 0 nmos l={nl} w={nw}

* cap out 0 {cload}

.control
    tran 10ns 1ns

    * ===== rc =====
    meas tran taurise trig v(rout) val=0.01 rise=1 targ v(rout) val=0.6321 rise=1 >/dev/null
    let pc = (taurise / 1e5) * 1e15
    meas tran taufall trig v(rout) val=0.99 fall=1 targ v(rout) val=0.3679 fall=1 >/dev/null
    let nc = (taufall / 1e5) * 1e15
    echo "pmos (rc)           =  $&pc   fF"
    echo "nmos (rc)           =  $&nc  fF"

    * ===== integral =====
    meas tran risecharge integ i(vreg) from=0 to=0.3ns >/dev/null
    let pc = -(risecharge / 1.0) * 1e15
    meas tran fallcharge integ i(vreg) from=0.45ns to=1ns >/dev/null
    let nc = (fallcharge / 1.0) * 1e15
    echo "pmos (integral)     =  $&pc  fF"
    echo "nmos (integral)     =  $&nc fF"

    * ===== equation =====
    let pc = (((3.9 * 8.854 * 1e-12) / (2.15 * 1e-9)) * 320 * 1e-9 * 90 * 1e-9) * 1e15
    let nc = (((3.9 * 8.854 * 1e-12) / (2.05 * 1e-9)) * 180 * 1e-9 * 90 * 1e-9) * 1e15
    echo "pmos (equation)     =  $&pc fF"
    echo "nmos (equation)     =  $&nc fF"

    * ===== delays =====
    meas tran tplhs trig v(in) val=0.5 fall=1 targ v(out) val=0.5 rise=1 >/dev/null
    meas tran tphls trig v(in) val=0.5 rise=1 targ v(out) val=0.5 fall=1 >/dev/null
    let td = ((tplhs + tphls) / 2) * 1e12
    let tplh = tplhs * 1e12
    let tphl = tphls * 1e12
    echo "tplh                =  $&tplh μs"
    echo "tphl                =  $&tphl μs"
    echo "td                  =  $&td μs"

    * ===== power =====
    * set wr_singlescale
    * wrdata plot/voltage.txt v(in) v(out)
    * let power = v(vdd) * i(vdd)
    * meas tran energy integ power from=0 to=1ns
    * let energy_fj = -energy * 1e15
    * echo "$&v_cur $&td $&energy_fj" >> plot/data.txt

.endc
.end
