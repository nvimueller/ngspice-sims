* ========================
* cmos inverter simulation
* ========================

* =========
* constants
* =========

.param voltage = 1.0v
.param pmos_width = 360nm
.param nmos_width = 180nm
.param pmos_length = 90nm
.param nmos_length = 90nm
* .param load_capacitance = 1ff

* ==============
* power supplies
* ==============

vdd vdd 0 dc {voltage}

* ==================
* input pulse source
* ==================

vin in 0 pulse(0 {voltage} 5ps 10ps 10ps 0.5ns 1ns)

* =========
* resistors
* =========

* rin in rout 1k

* ===========
* transistors
* ===========

mp out in vdd vdd pmos l={pmos_length} w={pmos_width}

mn out in 0 0 nmos l={nmos_length} w={nmos_width}

* ================
* load capacitance
* ================

* cload out 0 {load_capacitance}

* =============
* mosfet models
* =============

.include models/90nm.pm

* ===================
* simulation commands
* ===================

* ====================
* measurement commands
* ====================

* =======================
* save nodes for plotting
* =======================

.control
    tran 5fs 1ns

    * meas tran tplh trig v(in) val=0.5 fall=1 targ v(out) val=0.5 rise=1
    * meas tran tphl trig v(in) val=0.5 rise=1 targ v(out) val=0.5 fall=1
    * let original_td = ((tplh + tphl) / 2) * 1e9
    * set unit = ns
    * echo "original td         =  $&original_td$unit"
    * set wr_singlescale
    * wrdata plot/voltage.txt v(in) v(out)
    * let power = v(vdd) * i(vdd)
    * meas tran energy integ power from=0 to=1ns
    * let energy_fj = -energy * 1e15
    * echo "$&v_cur $&td $&energy_fj" >> plot/data.txt

    * ==
    * RC
    * ==
    * meas tran tau_rise trig v(out) val=0.0 rise=1 targ v(out) val=0.6321 rise=1
    * let pmos_cap = (tau_rise / 1e6) * 1e15
    * set unit = fF
    * echo "pmos_cap            =  $&pmos_cap $unit"
    * meas tran tau_fall trig v(out) val=1 fall=1 targ v(out) val=0.3679 fall=1
    * let nmos_cap = (tau_fall / 1e6) * 1e15
    * echo "nmos_cap            =  $&nmos_cap $unit"

    * ========
    * INTEGRAL
    * ========
    * meas tran rise_charge integ i(vin) from=0 to=0.3ns
    * let pmos_cap = -(rise_charge / 1.0) * 1e15
    * set unit = fF
    * echo "pmos_cap            =  $&pmos_cap $unit"
    * meas tran fall_charge integ i(vin) from=0.45ns to=1ns
    * let nmos_cap = (fall_charge / 1.0) * 1e15
    * set unit = fF
    * echo "nmos_cap            =  $&nmos_cap $unit"

    * ========
    * EQUATION
    * ========
    let pmos_cap = (((3.9 * 8.854 * 1e-12) / (2.15 * 1e-9)) * 320 * 1e-9 * 90 * 1e-9) * 1e15
    let nmos_cap = (((3.9 * 8.854 * 1e-12) / (2.05 * 1e-9)) * 180 * 1e-9 * 90 * 1e-9) * 1e15
    set unit = fF
    echo "nmos_cap            =  $&nmos_cap $unit"
    echo "pmos_cap            =  $&pmos_cap $unit"

.endc
.end
