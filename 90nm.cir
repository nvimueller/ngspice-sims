* ========================
* cmos inverter simulation
* ========================

* =========
* constants
* =========

.param voltage = 1.0V
.csparam ctrl_voltage = {voltage}
.param pmos_width = 360nm
.param nmos_width = 180nm
.param pmos_length = 90nm
.param nmos_length = 90nm
.param load_capacitance = 1fF

* ==============
* power supplies
* ==============

vdd vdd 0 dc {voltage}

* =====================
* 2. input pulse source
* =====================

vin in 0 pulse(0 {voltage} 5ps 100ps 100ps 0.5ns 1ns)

* ==============
* 3. transistors
* ==============

mp out in vdd vdd pmos l={pmos_length} w={pmos_width}

mn out in 0 0 nmos l={nmos_length} w={nmos_width}

* ===================
* 4. load capacitance
* ===================

cload out 0 {load_capacitance}

* ================
* 5. mosfet models
* ================

.include models/90nm.pm

* ======================
* 6. simulation commands
* ======================

* =======================
* 7. measurement commands
* =======================

* ==========================
* 8. save nodes for plotting
* ==========================

.control
    tran 5fs 1ns

    meas tran tplh trig v(in) val=0.5 fall=1 targ v(out) val=0.5 rise=1
    meas tran tphl trig v(in) val=0.5 rise=1 targ v(out) val=0.5 fall=1
    let original_td = ((tplh + tphl) / 2) * 1e9
    set unit = ns
    echo "original td         =  $&original_td$unit"

    set wr_singlescale
    wrdata plot/voltage.txt v(in) v(out)

    let const.v_start = 0.2
    let const.v_stop = 0.8
    let const.v_step = 0.01
    let const.v_cur = const.v_start

    while v_cur <= v_stop
        altermod nmos vth0 = $&v_cur
        altermod pmos vth0 = -$&v_cur

        tran 0.1ps 1ns

        meas tran tplh trig v(in) val=0.5 fall=1 targ v(out) val=0.5 rise=1
        meas tran tphl trig v(in) val=0.5 rise=1 targ v(out) val=0.5 fall=1
        let td = ((tplh + tphl) / 2) * 1e9

        let power = v(vdd) * i(vdd)
        meas tran energy integ power from=0 to=4ns
        let energy_fj = -energy * 1e15

        echo "$&v_cur $&td $&energy_fj" >> plot/data.txt

        let const.v_cur = const.v_cur + const.v_step
    end
.endc
.end
