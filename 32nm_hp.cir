* ========================
* cmos inverter simulation
* ========================

* =========
* constants
* =========

.param voltage = 1.0V
.csparam ctrl_voltage = {voltage}
.param pmos_width = 128nm
.param nmos_width = 64nm
.param pmos_length = 32nm
.param nmos_length = 32nm
.param pmos_threshold = -0.2V
.param nmos_threshold = 0.2V
.param load_capacitance = 1fF

* ==============
* power supplies
* ==============

vdd vdd 0 dc {voltage}

* =====================
* 2. input pulse source
* =====================

vin in 0 pulse(0 {voltage} 0.05n 0.03n 0.03n 5n 10n)

* ==============
* 3. transistors
* ==============

m1 out in vdd vdd pmos l={pmos_length} w={pmos_width}

m2 out in 0 0 nmos l={nmos_length} w={nmos_width}

* ===================
* 4. load capacitance
* ===================

cload out 0 {load_capacitance}

* ================
* 5. mosfet models
* ================

.include 32nm_hp.pm

* ======================
* 6. simulation commands
* ======================

* =======================
* 7. measurement commands
* =======================

* ==========================
* 8. save nodes for plotting
* ==========================

.control
    let v_start = 0.2 * $&ctrl_voltage
    let v_stop = 0.8 * $&ctrl_voltage
    let v_step = 0.01
    let v_cur = v_start

    while v_cur <= v_stop
        altermod nmos vth0 = $&v_cur
        altermod pmos vth0 = -$&v_cur

        tran 1p 10n

        meas tran tplh trig v(in) val=0.5 fall=1 targ v(out) val=0.5 rise=1
        meas tran tphl trig v(in) val=0.5 rise=1 targ v(out) val=0.5 fall=1

        let td = ((tplh + tphl) / 2) * 1e9

        echo "$&td $&v_cur" >> 32nm_hp.txt

        let v_cur = v_cur + v_step
    end
.endc
.end
