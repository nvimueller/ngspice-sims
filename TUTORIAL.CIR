* ========================
* CMOS INVERTER SIMULATION
* ========================

* ==============
* POWER SUPPLIES
* ==============

VDD VDD 0 DC 1.0
* VDD -> NAME OF SOURCE
* VDD -> POSITIVE NODE
* 0   -> GROUND NODE
* DC  -> DC VALUE TYPE
* 1.0 -> VOLTAGE IN VOLTS

* =====================
* 2. INPUT PULSE SOURCE
* =====================

VIN IN 0 PULSE(0 1.0 10M 0.1N 0.1N 50N 100N)

* VIN -> NAME OF SOURCE
* IN  -> POSITIVE NODE CONNECTED TO INVERTER INPUT
* 0   -> GROUND NODE
* PULSE(V1 V2 TD TR TF PW PER): PULSE WAVEFORM
*   V1  = 0    -> INITIAL VOLTAGE IN VOLTS
*   V2  = 1.0  -> PULSED VOLTAGE IN VOLTS
*   TD  = 10M  -> DELAY TIME BEFORE FIRST PULSE STARTS, IN SECONDS
*   TR  = 0.1N -> RISE TIME 0->1, IN SECONDS
*   TF  = 0.1N -> FALL TIME 1->0, IN SECONDS
*   PW  = 50N  -> PULSE WIDTH, TIME SIGNAL STAYS AT V2, IN SECONDS
*   PER = 100N -> PERIOD OF THE PULSE, IN SECONDS. 100NS = 10MHZ

* ==============
* 3. TRANSISTORS
* ==============

M1 OUT IN VDD VDD PMOS L=100N W=150N

* M1     -> PMOS TRANSISTOR NAME
* OUT    -> DRAIN NODE              = INVERTER OUTPUT
* IN     -> GATE NODE               = INVERTER INPUT
* VDD    -> SOURCE NODE             = TIED TO VDD
* VDD    -> BULK/BODY NODE          = TIED TO VDD FOR PMOS
* PMOS   -> MODEL NAME
* L=100N -> CHANNEL LENGTH
* W=200N -> CHANNEL WIDTH

M2 OUT IN 0 0 NMOS L=100N W=200N

* M2      -> NMOS TRANSISTOR NAME
* OUT     -> DRAIN NODE             = INVERTER OUTPUT
* IN      -> GATE NODE              = INVERTER INPUT
* 0       -> SOURCE NODE            = TIED TO GND
* 0       -> BULK/BODY NODE         = TIED TO GND FOR NMOS
* NMOS    -> MODEL NAME
* L=0.18U -> CHANNEL LENGTH
* W=0.25U -> CHANNEL WIDTH

* ===================
* 4. LOAD CAPACITANCE
* ===================

CLOAD OUT 0 10F

* CLOAD: NAME OF CAPACITOR
* OUT -> POSITIVE NODE CONNECTED TO OUTPUT
* 0   -> NEGATIVE NODE CONNECTED TO GROUND
* 10F -> CAPACITANCE VALUE = 10 FF = 10E-15 FARADS

* =======================================
* 5. MOSFET MODELS - LEVEL 1 SIMPLE MODEL
* =======================================

.MODEL NMOS NMOS LEVEL=1 VTO=0.4 KP=120U LAMBDA=0.06

* .MODEL      -> DEFINES A MODEL
* NMOS        -> MODEL NAME TO REFERENCE ABOVE
* NMOS        -> MODEL TYPE
* LEVEL=1     -> SHICHMAN-HODGES MODEL. SIMPLEST, GOOD FOR HAND CALC
* VTO=0.4     -> THRESHOLD VOLTAGE VTH IN VOLTS
* KP=120U     -> TRANSCONDUCTANCE PARAMETER U_N*COX IN A/V^2
* LAMBDA=0.06 -> CHANNEL LENGTH MODULATION IN 1/V

.MODEL PMOS PMOS LEVEL=1 VTO=-0.4 KP=40U LAMBDA=0.06

* VTO=-0.4    -> NEGATIVE THRESHOLD FOR PMOS
* KP=40U      -> LOWER MOBILITY FOR HOLES
* LAMBDA=0.06 -> SAME CHANNEL LENGTH MODULATION

* ======================
* 6. SIMULATION COMMANDS
* ======================

.TRAN 0.05N 200N

* .TRAN -> TRANSIENT ANALYSIS
* 0.05N -> TIMESTEP = 0.05 NS. MUST BE << RISE TIME FOR ACCURACY
* 200N  -> STOP TIME = 200 NS. SIMULATES 2 FULL PERIODS

* =======================
* 7. MEASUREMENT COMMANDS
* =======================

* FORMAT -> .MEASURE TRAN <RESULT_NAME> <TYPE> <ARGS>
* 'TRAN' MEANS MEASURE AFTER TRANSIENT SIM

* DELAY MEASUREMENTS -> 50% VDD CROSSING = 0.9V FOR 1.8V SUPPLY

.MEASURE TRAN TPHL TRIG V(IN) VAL=0.9 RISE=1 TARG V(OUT) VAL=0.9 FALL=1

* TPHL -> NAME OF RESULT = TPHL HIGH TO LOW DELAY
* TRIG -> TRIGGER CONDITION TO START TIMER
*   V(IN)   -> MONITOR INPUT VOLTAGE
*   VAL=0.9 -> WHEN IT CROSSES 0.9V
*   RISE=1  -> ON THE 1ST RISING EDGE
* TARG -> TARGET CONDITION TO STOP TIMER
*   V(OUT)  -> MONITOR OUTPUT VOLTAGE
*   VAL=0.9 -> WHEN IT CROSSES 0.9V
*   FALL=1  -> ON THE 1ST FALLING EDGE

.MEASURE TRAN TPLH TRIG V(IN) VAL=0.9 FALL=1 TARG V(OUT) VAL=0.9 RISE=1

* TPLH -> TPLH LOW TO HIGH DELAY. OPPOSITE EDGES OF TPHL

.MEASURE TRAN TPD PARAM='(TPHL+TPLH)/2'

* TPD   -> AVERAGE PROPAGATION DELAY
* PARAM -> CALCULATE FROM PREVIOUS MEASUREMENTS

* SLEW RATE MEASUREMENTS: 20% TO 80% POINTS

.MEASURE TRAN TRISE TRIG V(OUT) VAL=0.36 RISE=1 TARG V(OUT) VAL=1.44 RISE=1

* TRISE -> OUTPUT RISE TIME
* 0.36 = 20% OF 1.8V, 1.44 = 80% OF 1.8V

.MEASURE TRAN TFALL TRIG V(OUT) VAL=1.44 FALL=1 TARG V(OUT) VAL=0.36 FALL=1

* TFALL -> OUTPUT FALL TIME

* POWER MEASUREMENT

.MEASURE TRAN PAVG AVG P(VDD) FROM=50N TO=150N

* PAVG             -> AVERAGE POWER
* AVG              ->  TAKE AVERAGE
* P(VDD)           -> INSTANTANEOUS POWER FROM VDD SOURCE = V * I
* FROM=50N TO=150N -> ONLY AVERAGE OVER 1 FULL PERIOD TO AVOID STARTUP

* ==========================
* 8. SAVE NODES FOR PLOTTING
* ==========================

.SAVE V(IN) V(OUT) I(VDD)

* .SAVE  -> SAVE THESE FOR PLOT AFTER SIM
* V(IN)  ->  INPUT VOLTAGE WAVEFORM
* V(OUT) -> OUTPUT VOLTAGE WAVEFORM
* I(VDD) -> CURRENT FROM SUPPLY, USED FOR POWER

.CONTROL

RUN

* SET OUTPUT FORMAT TO PLAIN NUMBERS (OPTIONAL, DISABLES HEADERS)
SET ASCII_RAWFILE

* WRITE TIME, V(IN), AND V(OUT) INTO OUTPUT.TXT
WRDATA OUTPUT.TXT V(IN) V(OUT)

.ENDC

* .END -> END OF NETLIST
