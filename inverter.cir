VSRC VDD 0 DC 1.0V
VIN  IN  0 PULSE(0V 1.0V 0NS 50PS 50PS 500PS 2000PS)

M1 OUT IN 0   0   NMOS_MODEL W=0.5U L=0.06U
M2 OUT IN VDD VDD PMOS_MODEL W=1.2U L=0.06U

CLOAD OUT 0 10FF

.MODEL NMOS_MODEL NMOS (LEVEL=1 VTO=0.3 KP=120U)
.MODEL PMOS_MODEL PMOS (LEVEL=1 VTO=-0.3 KP=60U)

.TRAN 10PS 4NS

.CONTROL
  RUN
  ASCIIPLOT V(IN) V(OUT)
.ENDC

.END
