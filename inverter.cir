* CMOS Inverter Test
.title CMOS Inverter

Vdd vdd 0 5
Vss vss 0 0
Vin in 0 PULSE(0 5 0 1n 1n 50n 100n)

M1 out in vdd vdd pmos L=1u W=4u
M2 out in vss vss nmos L=1u W=2u

.model nmos nmos level=1 Vto=0.7 Kp=100u
.model pmos pmos level=1 Vto=-0.7 Kp=50u

.tran 0.1n 200n
.end
